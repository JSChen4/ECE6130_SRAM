ADE simulation setup
Run mode: Single Run, Sweeps and Corners
Tests:
  lab_ColumnDecoder_1: lab/ColumnMuxTest/schematic, simulator spectre
