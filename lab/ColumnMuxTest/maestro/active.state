ADE simulation setup
Test lab_ColumnDecoder_1: lab/ColumnMuxTest/schematic, simulator spectre
  Models: /nethome/yjia305/ECE6130_Updated/ECE6130_LAB/Cadence/INC/NMOS_THKOX.inc, /nethome/yjia305/ECE6130_Updated/ECE6130_LAB/Cadence/INC/NMOS_VTG.inc, /nethome/yjia305/ECE6130_Updated/ECE6130_LAB/Cadence/INC/NMOS_VTH.inc, /nethome/yjia305/ECE6130_Updated/ECE6130_LAB/Cadence/INC/NMOS_VTL.inc, /nethome/yjia305/ECE6130_Updated/ECE6130_LAB/Cadence/INC/PMOS_THKOX.inc, /nethome/yjia305/ECE6130_Updated/ECE6130_LAB/Cadence/INC/PMOS_VTG.inc, /nethome/yjia305/ECE6130_Updated/ECE6130_LAB/Cadence/INC/PMOS_VTH.inc, /nethome/yjia305/ECE6130_Updated/ECE6130_LAB/Cadence/INC/PMOS_VTL.inc
  Temperature: 27
  Analysis tran: stop=4n
  Output VT("/net32")
  Output VT("/net19")
  Output VT("/net17")
  Output VT("/I22/OUTPUT2")
  Output VT("/I22/net18")
  Output VT("/net12")
  Signals: /I22/OUTPUT2, /net32, /net19, /net17, /I22/net18, /net12
Run mode: Single Run, Sweeps and Corners
