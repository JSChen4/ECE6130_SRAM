ADE simulation setup
Run mode: Single Run, Sweeps and Corners
Tests:
  lab_columnDecoder_1: lab/GateTest/schematic, simulator spectre
