ADE simulation setup
Test lab_columnDecoder_1: lab/GateTest/schematic, simulator spectre
  Models: /nethome/yjia305/ECE6130_Updated/ECE6130_LAB/Cadence/INC/NMOS_THKOX.inc, /nethome/yjia305/ECE6130_Updated/ECE6130_LAB/Cadence/INC/NMOS_VTG.inc, /nethome/yjia305/ECE6130_Updated/ECE6130_LAB/Cadence/INC/NMOS_VTH.inc, /nethome/yjia305/ECE6130_Updated/ECE6130_LAB/Cadence/INC/NMOS_VTL.inc, /nethome/yjia305/ECE6130_Updated/ECE6130_LAB/Cadence/INC/PMOS_THKOX.inc, /nethome/yjia305/ECE6130_Updated/ECE6130_LAB/Cadence/INC/PMOS_VTG.inc, /nethome/yjia305/ECE6130_Updated/ECE6130_LAB/Cadence/INC/PMOS_VTH.inc, /nethome/yjia305/ECE6130_Updated/ECE6130_LAB/Cadence/INC/PMOS_VTL.inc
  Temperature: 27
  Analysis tran: stop=4n errpreset=conservative
  Signals: /net9, /net17, /net8, /net10, /net11, /net12, /net13
Run mode: Single Run, Sweeps and Corners
