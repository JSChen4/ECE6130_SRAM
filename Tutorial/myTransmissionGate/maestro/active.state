ADE simulation setup
Test Tutorial_myTransmissionGate_1: Tutorial/myTransmissionGate/schematic, simulator spectre
  Models: /nethome/jchen3014/ECE6130_Updated/ECE6130_LAB/Cadence/INC/NMOS_THKOX.inc, /nethome/jchen3014/ECE6130_Updated/ECE6130_LAB/Cadence/INC/NMOS_VTG.inc, /nethome/jchen3014/ECE6130_Updated/ECE6130_LAB/Cadence/INC/NMOS_VTH.inc, /nethome/jchen3014/ECE6130_Updated/ECE6130_LAB/Cadence/INC/NMOS_VTL.inc, /nethome/jchen3014/ECE6130_Updated/ECE6130_LAB/Cadence/INC/PMOS_THKOX.inc, /nethome/jchen3014/ECE6130_Updated/ECE6130_LAB/Cadence/INC/PMOS_VTG.inc, /nethome/jchen3014/ECE6130_Updated/ECE6130_LAB/Cadence/INC/PMOS_VTH.inc, /nethome/jchen3014/ECE6130_Updated/ECE6130_LAB/Cadence/INC/PMOS_VTL.inc
  Temperature: 27
  Analysis tran: stop=4n errpreset=conservative
  Signals: /net4 as output, /net5 as input
Run mode: Single Run, Sweeps and Corners
Device parameters:
  Tutorial/myTransmissionGate/schematic/M1.w = {Inclusion List}pmos_width{Inclusion List}{From/To}Auto:100:20:500{From/To}
