ADE simulation setup
Run mode: Single Run, Sweeps and Corners
Tests:
  Tutorial_myTransmissionGate_1: Tutorial/myTransmissionGate/schematic, simulator spectre
    Outputs: output; input; clk; clkb
Device parameters:
  Tutorial/myTransmissionGate/schematic/M1.w = {Inclusion List}pmos_width{Inclusion List}{From/To}Auto:100:20:500{From/To}
