ADE simulation setup
Run mode: Single Run, Sweeps and Corners
Tests:
  Tutorial_myFlipFlop_1: Tutorial/myFlipFlop/schematic, simulator spectre
    Outputs: input; output
