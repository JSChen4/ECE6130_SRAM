ADE simulation setup
Test Tutorial_myFlipFlop_1: Tutorial/myFlipFlop/schematic, simulator spectre
  Models: /nethome/jchen3014/ECE6130_Updated/ECE6130_LAB/Cadence/INC/NMOS_THKOX.inc, /nethome/jchen3014/ECE6130_Updated/ECE6130_LAB/Cadence/INC/NMOS_VTG.inc, /nethome/jchen3014/ECE6130_Updated/ECE6130_LAB/Cadence/INC/NMOS_VTH.inc, /nethome/jchen3014/ECE6130_Updated/ECE6130_LAB/Cadence/INC/NMOS_VTL.inc, /nethome/jchen3014/ECE6130_Updated/ECE6130_LAB/Cadence/INC/PMOS_THKOX.inc, /nethome/jchen3014/ECE6130_Updated/ECE6130_LAB/Cadence/INC/PMOS_VTG.inc, /nethome/jchen3014/ECE6130_Updated/ECE6130_LAB/Cadence/INC/PMOS_VTH.inc, /nethome/jchen3014/ECE6130_Updated/ECE6130_LAB/Cadence/INC/PMOS_VTL.inc
  Temperature: 27
  Analysis tran: stop=4n errpreset=conservative
  Signals: /net25 as input, /net24 as output
Run mode: Single Run, Sweeps and Corners
