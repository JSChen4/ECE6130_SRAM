ADE simulation setup
Test Tutorial_myInverter_1: Tutorial/myInverter/schematic, simulator spectre
  Models: /nethome/jchen3014/ECE6130_Updated/ECE6130_LAB/Cadence/INC/NMOS_THKOX.inc, /nethome/jchen3014/ECE6130_Updated/ECE6130_LAB/Cadence/INC/NMOS_VTG.inc, /nethome/jchen3014/ECE6130_Updated/ECE6130_LAB/Cadence/INC/NMOS_VTH.inc, /nethome/jchen3014/ECE6130_Updated/ECE6130_LAB/Cadence/INC/NMOS_VTL.inc, /nethome/jchen3014/ECE6130_Updated/ECE6130_LAB/Cadence/INC/PMOS_THKOX.inc, /nethome/jchen3014/ECE6130_Updated/ECE6130_LAB/Cadence/INC/PMOS_VTG.inc, /nethome/jchen3014/ECE6130_Updated/ECE6130_LAB/Cadence/INC/PMOS_VTH.inc, /nethome/jchen3014/ECE6130_Updated/ECE6130_LAB/Cadence/INC/PMOS_VTL.inc
  Variables: var_x = 50n
  Temperature: 27
  Analysis dc: sweep var_x start=0 stop=1
  Signals: /net2 as in, /net3 as out
Run mode: Single Run, Sweeps and Corners
Global variables:
  var_x = 50
Device parameters:
  Tutorial/myInverter/schematic/M1.w = {Inclusion List}var_x{Inclusion List}{From/To}Auto:100n:5:500n{From/To}
