ADE simulation setup
Run mode: Single Run, Sweeps and Corners
Tests:
  Tutorial_myInverter_1: Tutorial/myInverter/schematic, simulator spectre
    Variables: var_x = 50n
    Outputs: in; out
Global variables:
  var_x = 50
Device parameters:
  Tutorial/myInverter/schematic/M1.w = {Inclusion List}var_x{Inclusion List}{From/To}Auto:100n:5:500n{From/To}
